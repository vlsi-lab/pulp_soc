{
    name: "ntt_intt_pwm",
    clock_primary: "clk_i",
    reset_primary: "rst_ni",
    bus_device: "reg",
    bus_host: "",

    regwidth: "32",
    registers: [
        { multireg:
          { name: "DIN",
            desc: "Subword of input of ntt_intt_pwm module",
            count: "1",
            cname: "DIN",
            swaccess: "wo",
            fields: [
                { bits: "15:0"
                }
            ],
          }
        },
        { multireg:
          { name: "DOUT",
            desc: "Subword of results.",
            count: "1",
            cname: "dout",
            swaccess: "ro",
            hwaccess: "hwo",
            hwext: "true",
            fields: [
                { bits: "15:0"
                }
            ],
          }
        },
      { name: "CTRL",
        desc: "Controls signals of ntt_intt_pwm",
        cname: "ctrl",
        swaccess: "wo",
        hwaccess: "hro",
        hwext: "true",
        fields: [
            { bits: "0", name: "load_a_f",
				desc: "Make the ntt_intt_pwm starts collecting a_f"
            }
			{ bits: "1", name: "load_a_i",
				desc: "Make the ntt_intt_pwm starts collecting a_i"
            }
			{ bits: "2", name: "load_b_f",
				desc: "Make the ntt_intt_pwm starts collecting b_f"
            }
			{ bits: "3", name: "load_b_i",
				desc: "Make the ntt_intt_pwm starts collecting b_i"
            }
			{ bits: "4", name: "read_a",
				desc: "Make the ntt_intt_pwm starts reading a"
            }
			{ bits: "5", name: "read_b",
				desc: "Make the ntt_intt_pwm starts reading b"
            }
			{ bits: "6", name: "start_ab",
				desc: "---"
            }
			{ bits: "7", name: "start_ntt",
				desc: "Make the ntt_intt_pwm starts ntt"
            }
			{ bits: "8", name: "start_pwm",
				desc: "Make the ntt_intt_pwm starts pwm"
            }
			{ bits: "9", name: "start_intt",
				desc: "Make the ntt_intt_pwm starts intt"
            }
        ],
      },
	{ name: "STATUS"
	  desc: " Contains status information about ntt_intt_pwm"
	  swaccess: "ro",
	  hwaccess: "hwo",
	  hwext: "true",
	  fields: [
	      { bits: "0", name: "STATUS",
		desc: "If set output of keccack is valid"
	      }
	  ]	
	}
    ],
}
